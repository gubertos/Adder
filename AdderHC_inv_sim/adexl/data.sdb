ADE simulation setup
Run mode: Single Run, Sweeps and Corners
Tests:
  Adder:AdderHC_inv_sim:1: Adder/AdderHC_inv_sim/config, simulator ams
Global variables:
  k = 2
  ln = 180n
  wn = 240n
  CLK_PER = {Exclusion List}1000{Exclusion List}{From/To}Linear:960:20:1280{From/To}
  PAT = 100
Corners (nominal off):
  model folders: /cad/dk/umc180oa/cds/UMC_18_CMOS/../Models/Spectre
  ff (off): mm180_reg18_v124.lib.scs[ff]
  ss (off): mm180_reg18_v124.lib.scs[ss]
  fnsp (off): mm180_reg18_v124.lib.scs[fnsp]
  snfp: mm180_reg18_v124.lib.scs[snfp]
