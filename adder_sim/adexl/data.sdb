ADE simulation setup
Run mode: Single Run, Sweeps and Corners
Tests:
  Adder:adder_sim:1: Adder/adder_sim/config, simulator ams
    Outputs: TotalPower100
Global variables:
  CLK_PER = {Exclusion List}100000{Exclusion List}{From/To}Linear:1445:1:1455{From/To}
Corners:
  model folders: /cad/dk/umc180oa/cds/UMC_18_CMOS/../Models/Spectre
  ff (off): mm180_reg18_v124.lib.scs[ff]
  ss (off): mm180_reg18_v124.lib.scs[ss]
  fnsp (off): mm180_reg18_v124.lib.scs[fnsp]
  snfp (off): mm180_reg18_v124.lib.scs[snfp]
