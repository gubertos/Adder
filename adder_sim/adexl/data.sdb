ADE simulation setup
Run mode: Single Run, Sweeps and Corners
Tests:
  Adder:adder_sim:1: Adder/adder_sim/config, simulator ams
    Outputs: TotalPower100
Global variables:
  CLK_PER = 100000
  k = {Inclusion List}1.0{Inclusion List}{Inclusion List}1.5{Inclusion List}{Inclusion List}2.0{Inclusion List}{Inclusion List}2.5{Inclusion List}
  wn = 240n
  ln = 180n
Corners:
  model folders: /cad/dk/umc180oa/cds/UMC_18_CMOS/../Models/Spectre
  ff: mm180_reg18_v124.lib.scs[ff]
  ss: mm180_reg18_v124.lib.scs[ss]
  fnsp: mm180_reg18_v124.lib.scs[fnsp]
  snfp: mm180_reg18_v124.lib.scs[snfp]
