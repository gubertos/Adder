ADE simulation setup
Run mode: Single Run, Sweeps and Corners
Tests:
  Adder:adder_sim:1: Adder/adder_sim/config, simulator ams
Global variables:
  CLK_PER = {Inclusion List}800{Inclusion List}{From/To}Linear:800:5:900{From/To}
  k = 2
  wn = 240n
  ln = 180n
Corners:
  model folders: /cad/dk/umc180oa/cds/UMC_18_CMOS/../Models/Spectre
  ff: mm180_reg18_v124.lib.scs[ff]
  ss (off): mm180_reg18_v124.lib.scs[ss]
  fnsp (off): mm180_reg18_v124.lib.scs[fnsp]
  snfp (off): mm180_reg18_v124.lib.scs[snfp]
